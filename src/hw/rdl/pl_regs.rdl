`include "pl_regs.vh" //automatically created and added by fwk with conf variables such a C_VERSION ...

/* default values of defined variables */
`ifndef C_ID
`define C_ID 0xE1C00100
`endif
`ifndef C_VERSION
`define C_VERSION 0x00000000
`endif
`ifndef C_PRJ_ID
`define C_PRJ_ID 0xE1C00010
`endif
`ifndef C_PRJ_VERSION
`define C_PRJ_VERSION 0x00000000
`endif
`ifndef C_PRJ_TIMESTAMP
`define C_PRJ_TIMESTAMP 0x00000000
`endif
`ifndef C_PRJ_SHASUM
`define C_PRJ_SHASUM 0x00000000
`endif

/*
  module a address space
*/
addrmap pl_regs {
  name = "Example module for the example application";
  desyrdl_interface = "AXI4L";

  reg {
    desc = "Module Identification Number";
    default sw = r;
    default hw = r;
    field {} data[32] = `C_ID;
  } ID @0x00;

  reg {
    desc = "Module Version Number";
    default sw = r;
    default hw = r;
    field {} changes [8] =  `C_VERSION & 0x000000FF;
    field {} patch [8]   = (`C_VERSION & 0x0000FF00) >> 8;
    field {} minor [8]   = (`C_VERSION & 0x00FF0000) >> 16;
    field {} major [8]   = (`C_VERSION & 0xFF000000) >> 24;
  } VERSION @0x04;

  reg {
    desc="Project Identification Number";
    default sw = r;
    default hw = r;
    field {} data[32] = `C_PRJ_ID;
  } PRJ_ID @0x10;

  reg {
    desc="Project Version Number";
    default sw = r;
    default hw = r;
    field {} changes [8] =  `C_PRJ_VERSION & 0x000000FF;
    field {} patch [8]   = (`C_PRJ_VERSION & 0x0000FF00) >> 8;
    field {} minor [8]   = (`C_PRJ_VERSION & 0x00FF0000) >> 16;
    field {} major [8]   = (`C_PRJ_VERSION & 0xFF000000) >> 24;
  } PRJ_VERSION @0x14;

  reg {
    desc="Project Repository check sum.";
    default sw = r;
    default hw = r;
      field {} data[32] = `C_PRJ_SHASUM;
  } PRJ_SHASUM @0x18;

  reg {
    desc="Project compilation timestamp";
    default sw = r;
    default hw = r;
    field {} data[32] = `C_PRJ_TIMESTAMP;
  } PRJ_TIMESTAMP @0x1C;

  reg {
    desc="FP LED outputs";
    default sw = rw;
    default hw = r;
    field {} val[8];
  } fp_leds @0x20;


  reg {
    desc="ADC FIFO Reset";
    default sw = w;
    default hw = r;
    default swacc=true;
    default swmod=true;
    field {} data[1];
  } adcfifo_reset @0x40;

  reg {
    desc="ADC FIFO Trig";
    default sw = w;
    default hw = r;
    default swacc=true;
    default swmod=true;
    field {} data[1];
  } adcfifo_trig @0x44;


  reg {
    desc="ADC0 FIFO Data";
    default sw = rw;
    default hw = w;
    default swacc=true;
    default swmod=true;
    field {} data[32];
  } adc0fifo_dout @0x50;

   reg {
    desc="ADC0 FIFO Word Count";
    default sw = r;
    default hw = w;
    field {} data[32];
  } adc0fifo_wdcnt @0x54;

 reg {
    desc="ADC1 FIFO Data";
    default sw = rw;
    default hw = w;
    default swacc=true;
    default swmod=true;
    field {} data[32];
  } adc1fifo_dout @0x60;

   reg {
    desc="ADC1 FIFO Word Count";
    default sw = r;
    default hw = w;
    field {} data[32];
  } adc1fifo_wdcnt @0x64;
  
 reg {
    desc="ADC2 FIFO Data";
    default sw = rw;
    default hw = w;
    default swacc=true;
    default swmod=true;
    field {} data[32];
  } adc2fifo_dout @0x70;

   reg {
    desc="ADC2 FIFO Word Count";
    default sw = r;
    default hw = w;
    field {} data[32];
  } adc2fifo_wdcnt @0x74;

 reg {
    desc="ADC3 FIFO Data";
    default sw = rw;
    default hw = w;
    default swacc=true;
    default swmod=true;
    field {} data[32];
  } adc3fifo_dout @0x80;

   reg {
    desc="ADC3 FIFO Word Count";
    default sw = r;
    default hw = w;
    field {} data[32];
  } adc3fifo_wdcnt @0x84;
  






};
